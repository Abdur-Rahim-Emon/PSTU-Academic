* F:\EEE Lab\Rectifier.sch

* Schematics Version 9.1 - Web Update 1
* Mon Nov 18 08:08:33 2024

** Analysis setup **
.tran 0ns 5ms
.OP

* From [PSPICE NETLIST] section of pspiceev.ini:
.lib "nom.lib"

.INC "Rectifier.net"
.INC "Rectifier.als"

.probe

.END
