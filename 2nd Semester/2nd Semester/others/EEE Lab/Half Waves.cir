* F:\EEE Lab\Half Waves.sch

* Schematics Version 9.1 - Web Update 1
* Tue Jan 21 13:16:55 2025

** Analysis setup **
.tran 0ns 5ms
.OP

* From [PSPICE NETLIST] section of pspiceev.ini:
.lib "nom.lib"

.INC "Half Waves.net"
.INC "Half Waves.als"

.probe

.END
